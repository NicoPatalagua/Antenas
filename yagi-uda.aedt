# Ansys Electronics Desktop project, version 2018.0
materials:
  vacuum: permittivity=1
  silver: permeability=0.99998 conductivity=61000000
  air: permittivity=1.0006 permeability=1.0000004

design Antena (HFSS, DrivenModal, model units mm)
variables:
  lamda = 192mm
  diametro = 0.573mm
  separacion = 5mm
geometry:
  dipolo = cylinder(axis=X, base_centre=(0, 0mm, 0mm), radius=diametro/2, height=77.87mm)
  dipolo2 = cylinder(axis=X, base_centre=(-77.87mm, 0mm, 0mm), radius=diametro/2, height=77.87mm)
  reflector = cylinder(axis=X, base_centre=(-81.97mm, -59.02mm, 0mm), radius=diametro/2, height=(81.97*2) mm)
  director1 = cylinder(axis=X, base_centre=(-73.77mm, 29.5mm, 0mm), radius=diametro/2, height=147.54mm)
  director2 = cylinder(axis=X, base_centre=(-72.68mm, 88.52mm, 0mm), radius=diametro/2, height=145.36mm)
  director3 = cylinder(axis=X, base_centre=(-71.04mm, 147.54mm, 0mm), radius=diametro/2, height=142.08mm)
  centro [silver] = cylinder(axis=Y, base_centre=(0mm, -65.02mm, 0mm), radius=diametro/2, height=220mm)
  air [air] = cylinder(axis=Y, base_centre=(0mm, 180mm, 0mm), radius=152.31546mm, height=-280mm)
  centro.unite(dipolo, dipolo2, director1, director2, director3, reflector)
boundaries and excitations:
  Rad1: Radiation Objects=air
setups:
  Setup1: HfssDriven Frequency=915GHz MaxDeltaE=0.1 MaximumPasses=6 MinimumPasses=1 MinimumConvergedPasses=1 PercentRefinement=30 BasisOrder=1
    sweep Sweep1: 1.4GHz to 1.6GHz step 0.1GHz; Type=Fast SaveFields
