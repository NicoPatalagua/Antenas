# Ansys Electronics Desktop project, version 2018.0
materials:
  vacuum: permittivity=1
  perfect conductor: conductivity=1e+030
  Teflon (tm): permittivity=2.1 dielectric_loss_tangent=0.001
  air: permittivity=1.0006 permeability=1.0000004
  pec: conductivity=1e+030

design Normal (HFSS, DrivenModal, model units mm)
variables:
  S = 10.57mm
  D = 15mm
  N = 2
  h = 2mm
  lambda = 200mm
  Rad = 0.75mm
  ri = 0.46mm
  re = 1.47mm
geometry:
  coordinate_system RelativeCS1 = origin=(0mm, ri, h+0.5mm) x=(1mm, 0mm, 0mm) y=(0mm, 1mm, 0mm)
  PolygonHelix1 [pec] = user_primitive(SegmentedHelix/PolygonHelix.dll, PolygonSegments=0, PolygonRadius=Rad, StartHelixRadius=D/2, RadiusChange=0mm, Pitch=S, Turns=N, SegmentsPerTurn=36, RightHanded=0) in RelativeCS1
  Ground = circle(normal=Z, centre=(0mm, 0mm, 0mm), radius=D*2)
  Cylinder2 [Teflon (tm)] = cylinder(axis=Z, base_centre=(D/2, 0mm, 0mm), radius=re, height=-lambda/4)
  Cord [pec] = cylinder(axis=Z, base_centre=(D/2, 0mm, 0mm), radius=ri, height=-lambda/4)
  anillo_tierra = circle(normal=Z, centre=(D/2, 0mm, 0mm), radius=re)
  Ground.subtract(anillo_tierra)
  Cylinder1 = cylinder(axis=Z, base_centre=(D/2, 0mm, 0mm), radius=ri, height=-lambda/4)
  Cylinder2.subtract(Cylinder1)
  Port = circle(normal=Z, centre=(D/2, 0mm, -lambda/4), radius=re)
  puerto_int = circle(normal=Z, centre=(D/2, 0mm, -lambda/4), radius=ri)
  Port.subtract(puerto_int)
  Region [air] = region(absolute_offset=lambda/4 on all sides)
  planar = box(corner=(D/2-2*Rad, ri, -h), size=(4*Rad+0.5mm, -D, 2*h))
  PolygonHelix1.subtract(planar)
  acoplador = cylinder(axis=Z, base_centre=(D/2, 0mm, 0mm), radius=ri, height=h)
  PolygonHelix1.unite(acoplador)
boundaries and excitations:
  coaxial_externo: Perfect E Faces=Cylinder2.face(1 of 3)
  tierra: Perfect E Objects=Ground
  Rad1: Radiation Objects=Region
  1: Lumped Port Objects=Port Modes{Mode1{IntLine{Port.face(at (7.5, 0, -50)) -> Port.face(at (7.5, 0, -50))} CharImp=Zpi RenormImp=50ohm}} Impedance=50ohm
setups:
  Setup1: HfssDriven Frequency=1.5GHz MaxDeltaS=0.05 MaximumPasses=5 MinimumPasses=1 MinimumConvergedPasses=1 PercentRefinement=30 BasisOrder=1 PortAccuracy=2
    sweep Sweep: 1GHz to 2GHz step 0.05GHz; Type=Interpolating InterpTolerance=0.5 InterpMaxSolns=250 InterpUsePortImped=false PassivityErrorTolerance=0.0001
source amplitudes:
  1:1: 1W 0deg
optimetrics:
  ParametricSetup1: Parametric Sim._Setups=[Setup1]
    sweep h: LIN 1mm 6mm 1mm
  ParametricSetup2: Parametric Sim._Setups=[Setup1]
    sweep N: LIN 4 6 1
radiation setups:
  Infinite Sphere1: Infinite Sphere Theta=-180deg..180deg step 2deg Phi=-180deg..180deg step 2deg
reports:
  S Parameter Plot 1: dB(S(1,1)) vs Freq on Setup1 : Sweep; markers MX2 at x=1.5000001e+09
  VSWR Plot 1: VSWR(1) vs Freq on Setup1 : Sweep; markers MX2 at x=1.5000001e+09
  Z Parameter Plot 1: re(Z(1,1)), im(Z(1,1)) vs Freq on Setup1 : Sweep; markers MX2 at x=1.5000001e+09
  Gain Plot 1: GainTotal vs Phi, Theta on Setup1 : LastAdaptive, Infinite Sphere1 [Freq=1.5GHz]
  Gain Plot 2: GainTotal vs Theta on Setup1 : LastAdaptive, Infinite Sphere1 [Phi=0deg Freq=1.5GHz N=all h=all]
