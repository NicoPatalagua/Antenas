# Ansys Electronics Desktop project, version 2018.0
materials:
  vacuum: permittivity=1
  pec: conductivity=1e+030
  Teflon (tm): permittivity=2.1 dielectric_loss_tangent=0.001

design NormalMode_ATK (HFSS, DrivenTerminal, model units cm)
options: Allow_Material_Override open_region{BoundaryType=0 OpFreq=16GHz}
variables:
  # --Antenna Dimensions
  Helix_Diameter = 124.0876mm
  Helix_Spacing = 90mm
  Wire_Diameter = 2.8mm
  NumberOfTurns = 4
  # --Feed Dimensions
  coax_inner_rad = 0.15cm
  coax_outer_rad = 0.2cm
  feedLength = 1.5cm
  Pin_Length = 0.45cm
  Pin_Diameter = 0.3cm
  # --Ground Plane Dimensions
  groundX = 30cm
  groundY = 30cm
geometry:
  Helix1 [pec] = user_primitive(SegmentedHelix/PolygonHelix, PolygonSegments=8, PolygonRadius=Wire_Diameter/2, StartHelixRadius=Helix_Diameter/2, RadiusChange=0, Pitch=Helix_Spacing, Turns=NumberOfTurns, SegmentsPerTurn=16, RightHanded=0)
  Helix1.split(plane=XY, keep=PositiveOnly)
  ground = rectangle(corner=(-groundX/2, -groundY/2, -Pin_Length-Wire_Diameter/2), x_size=groundX, y_size=groundY)
  NewObject_1F8HU5 = circle(normal=Z, centre=(Helix_Diameter/2, 0cm, -Pin_Length-Wire_Diameter/2), radius=coax_outer_rad)
  ground.subtract(NewObject_1F8HU5)
  feed_pin = cylinder(axis=Z, base_centre=(Helix_Diameter/2, 0cm, -Pin_Length-Wire_Diameter/2), radius=Pin_Diameter/2, height=Pin_Length+Wire_Diameter/2)
  Helix1.unite(feed_pin)
  coax_pin [pec] = cylinder(axis=Z, base_centre=(Helix_Diameter/2, 0cm, -Pin_Length-Wire_Diameter/2), radius=coax_inner_rad, height=-feedLength)
  coax [Teflon (tm)] = cylinder(axis=Z, base_centre=(Helix_Diameter/2, 0cm, -Pin_Length-Wire_Diameter/2), radius=coax_outer_rad, height=-feedLength)
  port_cap [pec] = cylinder(axis=Z, base_centre=(Helix_Diameter/2, 0cm, -Pin_Length-Wire_Diameter/2-feedLength), radius=coax_outer_rad, height=-coax_outer_rad/2)
  port1 = circle(normal=Z, centre=(Helix_Diameter/2, 0cm, -Pin_Length-Wire_Diameter/2-feedLength), radius=coax_outer_rad)
  RadiatingSurface [vacuum] = region(absolute_offset=0.625cm on all sides)
boundaries and excitations:
  coax_outer: Perfect E Faces=coax.face(1 of 3)
  groundMetal: Perfect E Objects=ground
  AutoOpen1: Radiation Objects=RadiatingSurface
  coax_pin_T1: Terminal port=1 Faces=coax_pin.face(2 of 3) TerminalResistance=50ohm
  1: Wave Port Faces=port1.face NumModes=1
  reference conductors: port_cap
setups:
  ATK_Solution: HfssDriven Frequency=16GHz MaxDeltaS=0.02 MaximumPasses=15 MinimumPasses=1 MinimumConvergedPasses=1 PercentRefinement=30 BasisOrder=1 PortAccuracy=2 IESolverType=ACA
    sweep FF_Sweep: 0.5GHz to 2GHz step 0.5GHz; Type=Discrete SaveFields
    sweep SParam_Sweep: 8GHz to 24GHz, 100 points; Type=Interpolating InterpTolerance=0.5 InterpMaxSolns=250 PassivityErrorTolerance=0.0001
source amplitudes:
  1:1: 1V 0deg
radiation setups:
  3D: Infinite Sphere Theta=0deg..180deg step 2deg Phi=-180deg..180deg step 2deg
  Elevation: Infinite Sphere Theta=-180deg..180deg step 1deg Phi=0deg..90deg step 90deg
  Azimuth: Infinite Sphere Theta=90deg..90deg step 0deg Phi=-180deg..180deg step 1deg
  ATK_2D: Infinite Sphere Theta=-180deg..180deg step 1deg Phi=0deg..90deg step 90deg
  ATK_3D: Infinite Sphere Theta=-180deg..180deg step 2deg Phi=0deg..180deg step 5deg
reports:
  ff_3D_GainTotal: dB(GainTotal) vs Phi, Theta on ATK_Solution : LastAdaptive, ATK_3D [Freq=1.6e+10]
  ff_2D_GainTotal: dB(GainTotal) vs Theta on ATK_Solution : LastAdaptive, ATK_2D [Phi=all Freq=1.6e+10]
  ff_2D_GainTotal_Stacked: dB(GainTotal) vs Theta on ATK_Solution : FF_Sweep, ATK_2D [Phi=all Freq=all]
  Return Loss: dB(St11) vs Freq on ATK_Solution : SParam_Sweep
  Input Impedance: St11 on ATK_Solution : SParam_Sweep [Freq=all]
  Input Impedance_1: St11
  ff_2D_GainTotal_Stacked_1: dB(GainTotal), dB(GainTotal) vs Theta
  Terminal S Parameter Plot 1: dB(St(coax_pin_T1,coax_pin_T1)) vs Freq on ATK_Solution : FF_Sweep
  Terminal Z Parameter Plot 1: dBc(Zt(coax_pin_T1,coax_pin_T1)) vs Freq on ATK_Solution : FF_Sweep
